* NGSPICE file created from newflip1.ext - technology: sky130A

.subckt newflip1 a Q clk vdd vss
X0 a_20_10# clk vdd vdd sky130_fd_pr__pfet_01v8 ad=0.381 pd=3.14 as=0.381 ps=3.14 w=1.27 l=0.15
**devattr s=15240,628 d=15240,628
X1 a_3512_10# a_3112_10# vdd vdd sky130_fd_pr__pfet_01v8 ad=0.381 pd=3.14 as=0.381 ps=3.14 w=1.27 l=0.15
**devattr s=15240,628 d=15240,628
X2 vdd a_3112_10# Q vdd sky130_fd_pr__pfet_01v8 ad=0.381 pd=3.14 as=0.381 ps=3.14 w=1.27 l=0.15
**devattr s=15240,628 d=15240,628
X3 a_820_10# a_20_10# a_420_10# vss sky130_fd_pr__nfet_01v8 ad=0.126 pd=1.44 as=0.126 ps=1.44 w=0.42 l=0.15
**devattr s=5040,288 d=5040,288
X4 a_2712_10# a_20_10# a_3512_10# vss sky130_fd_pr__nfet_01v8 ad=0.126 pd=1.44 as=0.126 ps=1.44 w=0.42 l=0.15
**devattr s=5040,288 d=5040,288
X5 a_420_10# a vss vss sky130_fd_pr__nfet_01v8 ad=0.126 pd=1.44 as=0.126 ps=1.44 w=0.42 l=0.15
**devattr s=5040,288 d=5040,288
X6 a_420_10# a vdd vdd sky130_fd_pr__pfet_01v8 ad=0.381 pd=3.14 as=0.381 ps=3.14 w=1.27 l=0.15
**devattr s=15240,628 d=15240,628
X7 a_2712_10# clk a_1220_10# vss sky130_fd_pr__nfet_01v8 ad=0.126 pd=1.44 as=0.126 ps=1.44 w=0.42 l=0.15
**devattr s=5040,288 d=5040,288
X8 Q a_3112_10# vss vss sky130_fd_pr__nfet_01v8 ad=0.126 pd=1.44 as=0.126 ps=1.44 w=0.42 l=0.15
**devattr s=5040,288 d=5040,288
X9 a_3112_10# a_2712_10# vdd vdd sky130_fd_pr__pfet_01v8 ad=0.381 pd=3.14 as=0.381 ps=3.14 w=1.27 l=0.15
**devattr s=15240,628 d=15240,628
X10 vdd a_3112_10# Q vdd sky130_fd_pr__pfet_01v8 ad=0.381 pd=3.14 as=0.381 ps=3.14 w=1.27 l=0.15
**devattr s=15240,628 d=15240,628
X11 Q a_3112_10# vdd vdd sky130_fd_pr__pfet_01v8 ad=0.381 pd=3.14 as=0.381 ps=3.14 w=1.27 l=0.15
**devattr s=15240,628 d=15240,628
X12 a_3112_10# a_2712_10# vss vss sky130_fd_pr__nfet_01v8 ad=0.126 pd=1.44 as=0.126 ps=1.44 w=0.42 l=0.15
**devattr s=5040,288 d=5040,288
X13 a_3512_10# a_3112_10# vss vss sky130_fd_pr__nfet_01v8 ad=0.126 pd=1.44 as=0.126 ps=1.44 w=0.42 l=0.15
**devattr s=5040,288 d=5040,288
X14 a_2712_10# clk a_3512_10# vdd sky130_fd_pr__pfet_01v8 ad=0.381 pd=3.14 as=0.381 ps=3.14 w=1.27 l=0.15
**devattr s=15240,628 d=15240,628
X15 a_1620_10# a_1220_10# vdd vdd sky130_fd_pr__pfet_01v8 ad=0.381 pd=3.14 as=0.381 ps=3.14 w=1.27 l=0.15
**devattr s=15240,628 d=15240,628
X16 a_2712_10# a_20_10# a_1220_10# vdd sky130_fd_pr__pfet_01v8 ad=0.381 pd=3.14 as=0.381 ps=3.14 w=1.27 l=0.15
**devattr s=15240,628 d=15240,628
X17 a_20_10# clk vss vss sky130_fd_pr__nfet_01v8 ad=0.126 pd=1.44 as=0.126 ps=1.44 w=0.42 l=0.15
**devattr s=5040,288 d=5040,288
X18 a_1220_10# a_820_10# vdd vdd sky130_fd_pr__pfet_01v8 ad=0.381 pd=3.14 as=0.381 ps=3.14 w=1.27 l=0.15
**devattr s=15240,628 d=15240,628
X19 a_820_10# a_20_10# a_1620_10# vdd sky130_fd_pr__pfet_01v8 ad=0.381 pd=3.14 as=0.381 ps=3.14 w=1.27 l=0.15
**devattr s=15240,628 d=15240,628
X20 a_820_10# clk a_420_10# vdd sky130_fd_pr__pfet_01v8 ad=0.381 pd=3.14 as=0.381 ps=3.14 w=1.27 l=0.15
**devattr s=15240,628 d=15240,628
X21 a_820_10# clk a_1620_10# vss sky130_fd_pr__nfet_01v8 ad=0.126 pd=1.44 as=0.126 ps=1.44 w=0.42 l=0.15
**devattr s=5040,288 d=5040,288
X22 vss a_3112_10# Q vss sky130_fd_pr__nfet_01v8 ad=0.126 pd=1.44 as=0.126 ps=1.44 w=0.42 l=0.15
**devattr s=5040,288 d=5040,288
X23 a_1220_10# a_820_10# vss vss sky130_fd_pr__nfet_01v8 ad=0.126 pd=1.44 as=0.126 ps=1.44 w=0.42 l=0.15
**devattr s=5040,288 d=5040,288
X24 a_1620_10# a_1220_10# vss vss sky130_fd_pr__nfet_01v8 ad=0.126 pd=1.44 as=0.126 ps=1.44 w=0.42 l=0.15
**devattr s=5040,288 d=5040,288
C0 clk a_3512_10# 0.14043f
C1 vdd clk 2.03253f
C2 clk a_1220_10# 0.67349f
C3 Q a_20_10# 0.00416f
C4 a_1620_10# a_820_10# 0.29214f
C5 Q a_2712_10# 0.00409f
C6 vdd a_3512_10# 0.26273f
C7 vdd a_1220_10# 0.44813f
C8 a a_820_10# 0.00139f
C9 a_20_10# a_3112_10# 0.18541f
C10 a a_420_10# 0.03889f
C11 a_2712_10# a_3112_10# 0.53129f
C12 a_1620_10# clk 0.19621f
C13 a clk 0.02194f
C14 vdd a_1620_10# 0.25504f
C15 a_20_10# a_2712_10# 0.1427f
C16 a_1620_10# a_1220_10# 0.13205f
C17 a vdd 0.11687f
C18 Q clk 0
C19 a_3112_10# clk 0.04901f
C20 Q vdd 0.66603f
C21 a_20_10# a_820_10# 0.64225f
C22 a_2712_10# a_820_10# 0
C23 a_20_10# a_420_10# 0.2848f
C24 a_3112_10# a_3512_10# 0.16752f
C25 vdd a_3112_10# 0.7595f
C26 a_3112_10# a_1220_10# 0
C27 a_20_10# clk 1.04469f
C28 a_2712_10# clk 0.64975f
C29 a_420_10# a_820_10# 0.1755f
C30 a_20_10# a_3512_10# 0.16547f
C31 a_20_10# vdd 2.14675f
C32 a_20_10# a_1220_10# 0.20529f
C33 a_2712_10# a_3512_10# 0.25537f
C34 vdd a_2712_10# 0.45124f
C35 a_2712_10# a_1220_10# 0.17594f
C36 clk a_820_10# 0.19632f
C37 a_420_10# clk 0.20341f
C38 vdd a_820_10# 0.39027f
C39 a_820_10# a_1220_10# 0.57214f
C40 a_420_10# vdd 0.2362f
C41 a_20_10# a_1620_10# 0.18068f
C42 Q a_3112_10# 0.1733f
C43 a_420_10# a_1220_10# 0
C44 a_2712_10# a_1620_10# 0
C45 a a_20_10# 0.05767f
C46 Q vss 0.30901f
C47 vdd vss 7.96177f
C48 a vss 0.25781f
C49 clk vss 2.15927f
C50 a_3512_10# vss 0.21418f
C51 a_3112_10# vss 1.31837f
C52 a_2712_10# vss 0.4868f
C53 a_1620_10# vss 0.19334f
C54 a_1220_10# vss 0.63554f
C55 a_820_10# vss 0.51092f
C56 a_420_10# vss 0.18235f
C57 a_20_10# vss 1.64347f
.ends
